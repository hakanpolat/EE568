# Ansys Electronics Desktop project, version 2017.0
materials:
  NdFe35: permittivity=1 permeability=1.0997785 conductivity=625000 magnetic_coercivity{Magnitude=-890000A_per_meter DirComp1=1 DirComp2=0 DirComp3=0} lande_g_factor=2 mass_density=7400
  iron: permeability=4000 conductivity=10300000 mass_density=7870

design RMxprtDesign1 (RMxprt, Brushless Permanent-Magnet DC Motor, model units mm)
machine:
  Machine: FrictionLoss=0W WindLoss=0W ReferenceSpeed=600rpm NumberOfPoles=20 RotorPosition=true ControlType=0 CircuitType=Y3
  Circuit: TriggerPulseWidth=120deg TransistorDrop=0V DiodeDrop=0V LeadAngleOfTrigger=0deg MaximumCurrent=0A MinimumCurrent=0A
  Stator: SkewWidth=0 NumberOfSlots=21 LaminationSectors=0 PressBoardThickness=0mm OuterDiameter=270mm InnerDiameter=180mm Length=270mm StackingFactor=0.95 SteelType=iron SlotType=3
  Rotor: OuterDiameter=176mm InnerDiameter=100mm Length=270mm SteelType=iron PoleType=1 StackingFactor=0.95
  Shaft: MagneticShaft
  Stator Slot: Hs0=1mm Hs1=0mm Hs2=0mm Bs0=10mm Bs1=0mm Bs2=0mm Rs=0mm AutoDesign ToothWidth=0mm
  Stator Winding: WindingType=Whole-Coiled WindingLayers=2 ParallelBranches=1 ConductorsPerSlot=100 CoilPitch=1 EndAdjustment=0mm BaseInnerRadius=0mm TipInnerDiameter=0mm EndClearance=0mm CoilWrap=0mm SlotLiner=0mm WedgeThickness=0mm LayerInsulation=0mm BottomInsulation=0mm LimitedFillFactor=0.75 WdgNumberofPriodicMultipler=1 NumberOfStrands=10 WireWrap=0mm InterturnInsulation=0mm WireDiameter=0.574mm WireWidth=0mm WireThickness=0mm Gauge=23
  Rotor Pole: Embrace=0.7 Offset=0mm ShaftDiameter=0mm Bridge=0mm Rib=0mm MagnetThickness=2mm MagnetWidth=0mm MagnetType=NdFe35
setups:
  Setup1: BLDC Motor RatedOutputPower=8000W RatedVoltage=540V RatedSpeed=600rpm OperatingTemperature=75cel LoadType=ConstPower
